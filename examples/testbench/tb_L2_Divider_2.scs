// L2_Divider_2: Divide-by-2 Frequency Divider
simulator lang=spectre
global 0

ahdl_include "../veriloga/L2_Divider_2.va"

// 1GHz clock input (1ns period)
Vclk (clk_in 0) vsource type=pulse val0=0 val1=1.0 period=1n \
        rise=10p fall=10p

// DUT (port order: in out)
XDUT (clk_in clk_out) L2_Divider_2 ratio=2

tran tran stop=10n maxstep=10p
save clk_in clk_out
