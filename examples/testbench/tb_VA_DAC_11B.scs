// _VA_DAC_11B: Weighted DAC
simulator lang=spectre
global 0

ahdl_include "../veriloga/_VA_DAC_11B.va"

// RDY clock: 20ns period, delayed 5ns
Vrdy (rdy 0) vsource type=pulse val0=0 val1=0.9 period=20n delay=5n \
        rise=50p fall=50p

// DIN[12] (MSB): HIGH from 10ns onward
Vdin12 (din_12 0) vsource type=pwl wave=[0 0 9e-9 0 10e-9 0.9 80e-9 0.9]

// DIN[11..1]: HIGH from 30ns onward
Vdin11 (din_11 0) vsource type=pwl wave=[0 0 29e-9 0 30e-9 0.9 80e-9 0.9]
Vdin10 (din_10 0) vsource type=pwl wave=[0 0 29e-9 0 30e-9 0.9 80e-9 0.9]
Vdin9 (din_9 0) vsource type=pwl wave=[0 0 29e-9 0 30e-9 0.9 80e-9 0.9]
Vdin8 (din_8 0) vsource type=pwl wave=[0 0 29e-9 0 30e-9 0.9 80e-9 0.9]
Vdin7 (din_7 0) vsource type=pwl wave=[0 0 29e-9 0 30e-9 0.9 80e-9 0.9]
Vdin6 (din_6 0) vsource type=pwl wave=[0 0 29e-9 0 30e-9 0.9 80e-9 0.9]
Vdin5 (din_5 0) vsource type=pwl wave=[0 0 29e-9 0 30e-9 0.9 80e-9 0.9]
Vdin4 (din_4 0) vsource type=pwl wave=[0 0 29e-9 0 30e-9 0.9 80e-9 0.9]
Vdin3 (din_3 0) vsource type=pwl wave=[0 0 29e-9 0 30e-9 0.9 80e-9 0.9]
Vdin2 (din_2 0) vsource type=pwl wave=[0 0 29e-9 0 30e-9 0.9 80e-9 0.9]
Vdin1 (din_1 0) vsource type=pwl wave=[0 0 29e-9 0 30e-9 0.9 80e-9 0.9]

// DUT (port order: DIN[12] DIN[11] ... DIN[1] RDY AOUT)
XDUT (din_12 din_11 din_10 din_9 din_8 din_7 \
        din_6 din_5 din_4 din_3 din_2 din_1 \
        rdy aout) \
        _VA_DAC_11B vdd=0.9 vth=0.45

tran tran stop=80n maxstep=100p
save rdy din_12 din_6 din_1 aout
