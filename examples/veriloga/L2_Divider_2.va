// VerilogA for PLL_project, L2_Divider_2, veriloga

`include "constants.vams"
`include "disciplines.vams"

module L2_Divider_2 (in,out);

output out; voltage out;	// output
input in; voltage in;
parameter integer ratio=2;	// divide ratio

parameter real tt=10p from (0:inf);	// transition time of output signal
parameter real td=0 from [0:inf);	// average delay from input to output
integer count, n;

analog begin
    @(cross(V(in) - 0.5, +1)) begin
		count = count + 1; // count input transitions
		if (count >= ratio)
	 	   count = 0;
		n = (2*count >= ratio)? 1 : 0;
    end
    V(out) <+ transition(n, td, tt);
end
endmodule
